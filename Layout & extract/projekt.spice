* NGSPICE file created from projekt.ext - technology: scmos

.subckt projekt Vdd gnd A1 Q1 A2 Q2 A3 Q3 A4 Q4 A5 Q5 A6 Q6

* Top level circuit projekt

M1000 Q1 a_711_1360# Vdd w_561_1337# pfet w=10u l=0.2u
+  ad=168.03p pd=416.8u as=1088.67p ps=3673.6u
M1001 Q6 a_1361_1360# Vdd w_1207_1342# pfet w=10u l=0.2u
+  ad=168.03p pd=416.8u as=0p ps=0u
M1002 Q2 a_711_780# gnd Vss nfet w=9u l=0.2u
+  ad=296.63p pd=845u as=466.83p ps=1268.8u
M1003 Q5 a_1361_780# gnd Vss nfet w=9u l=0.2u
+  ad=116.03p pd=192.6u as=0p ps=0u
M1004 gnd a_1361_1360# Q6 Vss nfet w=9u l=0.2u
+  ad=0p pd=0u as=116.03p ps=192.6u
M1005 Q6 a_1361_1360# Vdd w_1207_1342# pfet w=10u l=0.2u
+  ad=0p pd=0u as=0p ps=0u
M1006 Q4 a_1361_200# Vdd w_1208_184# pfet w=10u l=0.2u
+  ad=168.03p pd=416.8u as=0p ps=0u
M1007 Vdd a_1307_1354# a_1361_1360# w_1207_1342# pfet w=11.1u l=0.2u
+  ad=0p pd=0u as=19.98p ps=70.2u
M1008 a_657_774# a_597_763# Vdd w_557_759# pfet w=3.6u l=0.2u
+  ad=4.32p pd=16.8u as=0p ps=0u
M1009 Q1 a_711_1360# Vdd w_561_1337# pfet w=10u l=0.2u
+  ad=0p pd=0u as=0p ps=0u
M1010 a_1307_1354# a_1247_1343# gnd Vss nfet w=3.2u l=0.2u
+  ad=1.92p pd=7.6u as=0p ps=0u
M1011 Q3 a_711_200# gnd Vss nfet w=9u l=0.2u
+  ad=116.03p pd=192.6u as=0p ps=0u
M1012 Vdd a_1361_780# Q5 w_1211_757# pfet w=10u l=0.2u
+  ad=0p pd=0u as=168.03p ps=416.8u
M1013 Q2 a_711_780# Vdd w_557_759# pfet w=10u l=0.2u
+  ad=168.03p pd=416.8u as=0p ps=0u
M1014 Q6 a_1361_1360# Vdd w_1207_1342# pfet w=10u l=0.2u
+  ad=0p pd=0u as=0p ps=0u
M1015 gnd a_1361_200# Q4 Vss nfet w=9u l=0.2u
+  ad=0p pd=0u as=116.03p ps=192.6u
M1016 Q1 a_711_1360# Vdd w_561_1337# pfet w=10u l=0.2u
+  ad=0p pd=0u as=0p ps=0u
M1017 gnd a_1361_1360# Q6 Vss nfet w=9u l=0.2u
+  ad=0p pd=0u as=0p ps=0u
M1018 Vdd a_1217_183# a_1247_183# w_1208_184# pfet w=4u l=0.2u
+  ad=0p pd=0u as=2.8p ps=9.4u
M1019 Q3 a_711_200# Vdd w_558_177# pfet w=10u l=0.2u
+  ad=168.03p pd=416.8u as=0p ps=0u
M1020 gnd a_711_1360# Q1 Vss nfet w=9u l=0.2u
+  ad=0p pd=0u as=116.33p ps=192.6u
M1021 Vdd a_1361_200# Q4 w_1208_184# pfet w=10u l=0.2u
+  ad=0p pd=0u as=0p ps=0u
M1022 a_711_1360# a_657_1354# Vdd w_561_1337# pfet w=11.1u l=0.2u
+  ad=19.98p pd=70.2u as=0p ps=0u
M1023 Vdd a_711_200# Q3 w_558_177# pfet w=10u l=0.2u
+  ad=0p pd=0u as=0p ps=0u
M1024 a_711_1360# a_657_1354# gnd Vss nfet w=6.5u l=0.2u
+  ad=10.4p pd=42.2u as=0p ps=0u
M1025 Vdd a_711_780# Q2 w_557_759# pfet w=10u l=0.2u
+  ad=0p pd=0u as=0p ps=0u
M1026 Vdd a_1361_780# Q5 w_1211_757# pfet w=10u l=0.2u
+  ad=0p pd=0u as=0p ps=0u
M1027 Q2 a_711_780# Vdd w_557_759# pfet w=10u l=0.2u
+  ad=0p pd=0u as=0p ps=0u
M1028 Vdd a_1361_780# Q5 w_1211_757# pfet w=10u l=0.2u
+  ad=0p pd=0u as=0p ps=0u
M1029 a_657_1354# a_597_1343# Vdd w_561_1337# pfet w=3.6u l=0.2u
+  ad=4.32p pd=16.8u as=0p ps=0u
M1030 Q1 a_711_1360# Vdd w_561_1337# pfet w=10u l=0.2u
+  ad=0p pd=0u as=0p ps=0u
M1031 Q6 a_1361_1360# Vdd w_1207_1342# pfet w=10u l=0.2u
+  ad=0p pd=0u as=0p ps=0u
M1032 Vdd a_711_1360# Q1 w_561_1337# pfet w=10u l=0.2u
+  ad=0p pd=0u as=0p ps=0u
M1033 Q3 a_711_200# gnd Vss nfet w=9u l=0.2u
+  ad=0p pd=0u as=0p ps=0u
M1034 gnd a_1361_780# Q5 Vss nfet w=9u l=0.2u
+  ad=0p pd=0u as=0p ps=0u
M1035 Vdd a_657_194# a_711_200# w_558_177# pfet w=11.1u l=0.2u
+  ad=0p pd=0u as=19.98p ps=70.2u
M1036 Vdd a_1361_1360# Q6 w_1207_1342# pfet w=10u l=0.2u
+  ad=0p pd=0u as=0p ps=0u
M1037 gnd a_711_1360# Q1 Vss nfet w=9u l=0.2u
+  ad=0p pd=0u as=0p ps=0u
M1038 a_567_763# A2 gnd Vss nfet w=0.4u l=0.2u
+  ad=0.2p pd=1.8u as=0p ps=0u
M1039 Q3 a_711_200# Vdd w_558_177# pfet w=10u l=0.2u
+  ad=0p pd=0u as=0p ps=0u
M1040 Vdd a_1361_200# Q4 w_1208_184# pfet w=10u l=0.2u
+  ad=0p pd=0u as=0p ps=0u
M1041 Vdd a_1247_763# a_1307_774# w_1211_757# pfet w=3.6u l=0.2u
+  ad=0p pd=0u as=4.32p ps=16.8u
M1042 Vdd a_1307_194# a_1361_200# w_1208_184# pfet w=11.1u l=0.2u
+  ad=0p pd=0u as=19.98p ps=70.2u
M1043 Q5 a_1361_780# Vdd w_1211_757# pfet w=10u l=0.2u
+  ad=0p pd=0u as=0p ps=0u
M1044 a_1361_1360# a_1307_1354# Vdd w_1207_1342# pfet w=11.1u l=0.2u
+  ad=0p pd=0u as=0p ps=0u
M1045 gnd a_711_200# Q3 Vss nfet w=9u l=0.2u
+  ad=0p pd=0u as=0p ps=0u
M1046 gnd a_1361_200# Q4 Vss nfet w=9u l=0.2u
+  ad=0p pd=0u as=0p ps=0u
M1047 Q2 a_711_780# Vdd w_557_759# pfet w=10u l=0.2u
+  ad=0p pd=0u as=0p ps=0u
M1048 Vdd a_1361_780# Q5 w_1211_757# pfet w=10u l=0.2u
+  ad=0p pd=0u as=0p ps=0u
M1049 Q1 a_711_1360# Vdd w_561_1337# pfet w=10u l=0.2u
+  ad=0p pd=0u as=0p ps=0u
M1050 a_1361_1360# a_1307_1354# gnd Vss nfet w=6.5u l=0.2u
+  ad=10.4p pd=42.2u as=0p ps=0u
M1051 Vdd a_1361_1360# Q6 w_1207_1342# pfet w=10u l=0.2u
+  ad=0p pd=0u as=0p ps=0u
M1052 Q4 a_1361_200# gnd Vss nfet w=9u l=0.2u
+  ad=0p pd=0u as=0p ps=0u
M1053 Vdd a_1361_200# Q4 w_1208_184# pfet w=10u l=0.2u
+  ad=0p pd=0u as=0p ps=0u
M1054 gnd a_711_780# Q2 Vss nfet w=9u l=0.2u
+  ad=0p pd=0u as=0p ps=0u
M1055 Vdd A2 a_567_763# w_557_759# pfet w=1u l=0.2u
+  ad=0p pd=0u as=0.6p ps=3.2u
M1056 a_657_194# a_597_183# gnd Vss nfet w=3.2u l=0.2u
+  ad=1.92p pd=7.6u as=0p ps=0u
M1057 Q3 a_711_200# Vdd w_558_177# pfet w=10u l=0.2u
+  ad=0p pd=0u as=0p ps=0u
M1058 Vdd a_711_200# Q3 w_558_177# pfet w=10u l=0.2u
+  ad=0p pd=0u as=0p ps=0u
M1059 Q4 a_1361_200# Vdd w_1208_184# pfet w=10u l=0.2u
+  ad=0p pd=0u as=0p ps=0u
M1060 Q6 a_1361_1360# gnd Vss nfet w=9u l=0.2u
+  ad=0p pd=0u as=0p ps=0u
M1061 Vdd a_1361_780# Q5 w_1211_757# pfet w=10u l=0.2u
+  ad=0p pd=0u as=0p ps=0u
M1062 Q5 a_1361_780# Vdd w_1211_757# pfet w=10u l=0.2u
+  ad=0p pd=0u as=0p ps=0u
M1063 Q1 a_711_1360# Vdd w_561_1337# pfet w=10u l=0.2u
+  ad=0p pd=0u as=0p ps=0u
M1064 Vdd a_711_780# Q2 w_557_759# pfet w=10u l=0.2u
+  ad=0p pd=0u as=0p ps=0u
M1065 gnd a_711_200# Q3 Vss nfet w=9u l=0.2u
+  ad=0p pd=0u as=0p ps=0u
M1066 Q5 a_1361_780# gnd Vss nfet w=9u l=0.2u
+  ad=0p pd=0u as=0p ps=0u
M1067 Vdd a_1361_1360# Q6 w_1207_1342# pfet w=10u l=0.2u
+  ad=0p pd=0u as=0p ps=0u
M1068 Q6 a_1361_1360# Vdd w_1207_1342# pfet w=10u l=0.2u
+  ad=0p pd=0u as=0p ps=0u
M1069 gnd a_711_780# Q2 Vss nfet w=9u l=0.2u
+  ad=0p pd=0u as=0p ps=0u
M1070 Q1 a_711_1360# gnd Vss nfet w=9u l=0.2u
+  ad=0p pd=0u as=0p ps=0u
M1071 Vdd a_1361_200# Q4 w_1208_184# pfet w=10u l=0.2u
+  ad=0p pd=0u as=0p ps=0u
M1072 Q6 a_1361_1360# gnd Vss nfet w=9u l=0.2u
+  ad=0p pd=0u as=0p ps=0u
M1073 Q3 a_711_200# Vdd w_558_177# pfet w=10u l=0.2u
+  ad=0p pd=0u as=0p ps=0u
M1074 Vdd a_597_763# a_657_774# w_557_759# pfet w=3.6u l=0.2u
+  ad=0p pd=0u as=0p ps=0u
M1075 Vdd a_711_780# Q2 w_557_759# pfet w=10u l=0.2u
+  ad=0p pd=0u as=0p ps=0u
M1076 Vdd a_1361_780# Q5 w_1211_757# pfet w=10u l=0.2u
+  ad=0p pd=0u as=0p ps=0u
M1077 Q4 a_1361_200# gnd Vss nfet w=9u l=0.2u
+  ad=0p pd=0u as=0p ps=0u
M1078 Vdd a_711_1360# Q1 w_561_1337# pfet w=10u l=0.2u
+  ad=0p pd=0u as=0p ps=0u
M1079 Q2 a_711_780# Vdd w_557_759# pfet w=10u l=0.2u
+  ad=0p pd=0u as=0p ps=0u
M1080 Q5 a_1361_780# gnd Vss nfet w=9u l=0.2u
+  ad=0p pd=0u as=0p ps=0u
M1081 Q1 a_711_1360# Vdd w_561_1337# pfet w=10u l=0.2u
+  ad=0p pd=0u as=0p ps=0u
M1082 Vdd a_1361_1360# Q6 w_1207_1342# pfet w=10u l=0.2u
+  ad=0p pd=0u as=0p ps=0u
M1083 Q2 a_711_780# gnd Vss nfet w=9u l=0.2u
+  ad=0p pd=0u as=0p ps=0u
M1084 Q3 a_711_200# Vdd w_558_177# pfet w=10u l=0.2u
+  ad=0p pd=0u as=0p ps=0u
M1085 gnd a_1247_183# a_1307_194# Vss nfet w=3.2u l=0.2u
+  ad=0p pd=0u as=1.92p ps=7.6u
M1086 Vdd a_1361_200# Q4 w_1208_184# pfet w=10u l=0.2u
+  ad=0p pd=0u as=0p ps=0u
M1087 Q3 a_711_200# Vdd w_558_177# pfet w=10u l=0.2u
+  ad=0p pd=0u as=0p ps=0u
M1088 Q2 a_711_780# Vdd w_557_759# pfet w=10u l=0.2u
+  ad=0p pd=0u as=0p ps=0u
M1089 a_657_1354# a_597_1343# Vdd w_561_1337# pfet w=3.6u l=0.2u
+  ad=0p pd=0u as=0p ps=0u
M1090 Vdd a_711_780# Q2 w_557_759# pfet w=10u l=0.2u
+  ad=0p pd=0u as=0p ps=0u
M1091 Q5 a_1361_780# Vdd w_1211_757# pfet w=10u l=0.2u
+  ad=0p pd=0u as=0p ps=0u
M1092 Vdd a_711_1360# Q1 w_561_1337# pfet w=10u l=0.2u
+  ad=0p pd=0u as=0p ps=0u
M1093 Q3 a_711_200# gnd Vss nfet w=9u l=0.2u
+  ad=0p pd=0u as=0p ps=0u
M1094 Vdd A1 a_567_1343# w_561_1337# pfet w=1u l=0.2u
+  ad=0p pd=0u as=0.6p ps=3.2u
M1095 Vdd a_657_194# a_711_200# w_558_177# pfet w=11.1u l=0.2u
+  ad=0p pd=0u as=0p ps=0u
M1096 Vdd a_1361_1360# Q6 w_1207_1342# pfet w=10u l=0.2u
+  ad=0p pd=0u as=0p ps=0u
M1097 Q2 a_711_780# gnd Vss nfet w=9u l=0.2u
+  ad=0p pd=0u as=0p ps=0u
M1098 a_597_183# a_567_183# gnd Vss nfet w=1.6u l=0.2u
+  ad=0.8p pd=4.2u as=0p ps=0u
M1099 gnd a_711_1360# Q1 Vss nfet w=9u l=0.2u
+  ad=0p pd=0u as=0p ps=0u
M1100 gnd a_1361_1360# Q6 Vss nfet w=9u l=0.2u
+  ad=0p pd=0u as=0p ps=0u
M1101 Q3 a_711_200# Vdd w_558_177# pfet w=10u l=0.2u
+  ad=0p pd=0u as=0p ps=0u
M1102 Vdd a_1361_200# Q4 w_1208_184# pfet w=10u l=0.2u
+  ad=0p pd=0u as=0p ps=0u
M1103 a_711_200# a_657_194# gnd Vss nfet w=6.5u l=0.2u
+  ad=10.4p pd=42.2u as=0p ps=0u
M1104 Vdd a_1307_194# a_1361_200# w_1208_184# pfet w=11.1u l=0.2u
+  ad=0p pd=0u as=0p ps=0u
M1105 Q5 a_1361_780# Vdd w_1211_757# pfet w=10u l=0.2u
+  ad=0p pd=0u as=0p ps=0u
M1106 a_1247_183# a_1217_183# gnd Vss nfet w=1.6u l=0.2u
+  ad=0.8p pd=4.2u as=0p ps=0u
M1107 Q1 a_711_1360# Vdd w_561_1337# pfet w=10u l=0.2u
+  ad=0p pd=0u as=0p ps=0u
M1108 a_711_780# a_657_774# gnd Vss nfet w=6.5u l=0.2u
+  ad=10.4p pd=42.2u as=0p ps=0u
M1109 Vdd a_711_780# Q2 w_557_759# pfet w=10u l=0.2u
+  ad=0p pd=0u as=0p ps=0u
M1110 Q5 a_1361_780# Vdd w_1211_757# pfet w=10u l=0.2u
+  ad=0p pd=0u as=0p ps=0u
M1111 a_711_200# a_657_194# Vdd w_558_177# pfet w=11.1u l=0.2u
+  ad=0p pd=0u as=0p ps=0u
M1112 a_1361_200# a_1307_194# gnd Vss nfet w=6.5u l=0.2u
+  ad=10.4p pd=42.2u as=0p ps=0u
M1113 Q6 a_1361_1360# Vdd w_1207_1342# pfet w=10u l=0.2u
+  ad=0p pd=0u as=0p ps=0u
M1114 Vdd a_1361_1360# Q6 w_1207_1342# pfet w=10u l=0.2u
+  ad=0p pd=0u as=0p ps=0u
M1115 a_711_1360# a_657_1354# Vdd w_561_1337# pfet w=11.1u l=0.2u
+  ad=0p pd=0u as=0p ps=0u
M1116 gnd a_1361_780# Q5 Vss nfet w=9u l=0.2u
+  ad=0p pd=0u as=0p ps=0u
M1117 Vdd a_567_183# a_597_183# w_558_177# pfet w=4u l=0.2u
+  ad=0p pd=0u as=2.8p ps=9.4u
M1118 Q4 a_1361_200# Vdd w_1208_184# pfet w=10u l=0.2u
+  ad=0p pd=0u as=0p ps=0u
M1119 a_1361_780# a_1307_774# gnd Vss nfet w=6.5u l=0.2u
+  ad=10.4p pd=42.2u as=0p ps=0u
M1120 a_711_780# a_657_774# Vdd w_557_759# pfet w=11.1u l=0.2u
+  ad=19.98p pd=70.2u as=0p ps=0u
M1121 Vdd a_711_200# Q3 w_558_177# pfet w=10u l=0.2u
+  ad=0p pd=0u as=0p ps=0u
M1122 a_1361_200# a_1307_194# Vdd w_1208_184# pfet w=11.1u l=0.2u
+  ad=0p pd=0u as=0p ps=0u
M1123 a_1307_194# a_1247_183# Vdd w_1208_184# pfet w=3.6u l=0.2u
+  ad=4.32p pd=16.8u as=0p ps=0u
M1124 Vdd a_1361_200# Q4 w_1208_184# pfet w=10u l=0.2u
+  ad=0p pd=0u as=0p ps=0u
M1125 Q5 a_1361_780# Vdd w_1211_757# pfet w=10u l=0.2u
+  ad=0p pd=0u as=0p ps=0u
M1126 a_1307_774# a_1247_763# gnd Vss nfet w=3.2u l=0.2u
+  ad=1.92p pd=7.6u as=0p ps=0u
M1127 a_1361_780# a_1307_774# Vdd w_1211_757# pfet w=11.1u l=0.2u
+  ad=19.98p pd=70.2u as=0p ps=0u
M1128 Vdd a_711_780# Q2 w_557_759# pfet w=10u l=0.2u
+  ad=0p pd=0u as=0p ps=0u
M1129 Vdd a_711_1360# Q1 w_561_1337# pfet w=10u l=0.2u
+  ad=0p pd=0u as=0p ps=0u
M1130 Vdd a_1361_1360# Q6 w_1207_1342# pfet w=10u l=0.2u
+  ad=0p pd=0u as=0p ps=0u
M1131 gnd a_711_780# Q2 Vss nfet w=9u l=0.2u
+  ad=0p pd=0u as=0p ps=0u
M1132 Q1 a_711_1360# gnd Vss nfet w=9u l=0.2u
+  ad=0p pd=0u as=0p ps=0u
M1133 gnd a_1361_780# Q5 Vss nfet w=9u l=0.2u
+  ad=0p pd=0u as=0p ps=0u
M1134 Vdd a_1361_200# Q4 w_1208_184# pfet w=10u l=0.2u
+  ad=0p pd=0u as=0p ps=0u
M1135 Q6 a_1361_1360# gnd Vss nfet w=9u l=0.2u
+  ad=0p pd=0u as=0p ps=0u
M1136 a_1361_1360# a_1307_1354# Vdd w_1207_1342# pfet w=11.1u l=0.2u
+  ad=0p pd=0u as=0p ps=0u
M1137 Vdd a_711_200# Q3 w_558_177# pfet w=10u l=0.2u
+  ad=0p pd=0u as=0p ps=0u
M1138 Vdd a_597_763# a_657_774# w_557_759# pfet w=3.6u l=0.2u
+  ad=0p pd=0u as=0p ps=0u
M1139 Vdd a_711_1360# Q1 w_561_1337# pfet w=10u l=0.2u
+  ad=0p pd=0u as=0p ps=0u
M1140 Q2 a_711_780# Vdd w_557_759# pfet w=10u l=0.2u
+  ad=0p pd=0u as=0p ps=0u
M1141 gnd a_1247_1343# a_1307_1354# Vss nfet w=3.2u l=0.2u
+  ad=0p pd=0u as=0p ps=0u
M1142 gnd a_711_200# Q3 Vss nfet w=9u l=0.2u
+  ad=0p pd=0u as=0p ps=0u
M1143 Vdd a_1217_1343# a_1247_1343# w_1207_1342# pfet w=4u l=0.2u
+  ad=0p pd=0u as=2.8p ps=9.4u
M1144 Vdd a_711_780# Q2 w_557_759# pfet w=10u l=0.2u
+  ad=0p pd=0u as=0p ps=0u
M1145 Vdd a_1361_1360# Q6 w_1207_1342# pfet w=10u l=0.2u
+  ad=0p pd=0u as=0p ps=0u
M1146 Vdd a_711_1360# Q1 w_561_1337# pfet w=10u l=0.2u
+  ad=0p pd=0u as=0p ps=0u
M1147 gnd a_657_774# a_711_780# Vss nfet w=6.5u l=0.2u
+  ad=0p pd=0u as=0p ps=0u
M1148 Q1 a_711_1360# gnd Vss nfet w=9u l=0.2u
+  ad=0p pd=0u as=0p ps=0u
M1149 Q4 a_1361_200# gnd Vss nfet w=9u l=0.2u
+  ad=0p pd=0u as=0p ps=0u
M1150 Q6 a_1361_1360# gnd Vss nfet w=9u l=0.2u
+  ad=0p pd=0u as=0p ps=0u
M1151 Vdd a_711_200# Q3 w_558_177# pfet w=10u l=0.2u
+  ad=0p pd=0u as=0p ps=0u
M1152 Q4 a_1361_200# Vdd w_1208_184# pfet w=10u l=0.2u
+  ad=0p pd=0u as=0p ps=0u
M1153 Vdd a_657_1354# a_711_1360# w_561_1337# pfet w=11.1u l=0.2u
+  ad=0p pd=0u as=0p ps=0u
M1154 Q3 a_711_200# Vdd w_558_177# pfet w=10u l=0.2u
+  ad=0p pd=0u as=0p ps=0u
M1155 gnd a_1307_774# a_1361_780# Vss nfet w=6.5u l=0.2u
+  ad=0p pd=0u as=0p ps=0u
M1156 gnd a_657_1354# a_711_1360# Vss nfet w=6.5u l=0.2u
+  ad=0p pd=0u as=0p ps=0u
M1157 Q2 a_711_780# Vdd w_557_759# pfet w=10u l=0.2u
+  ad=0p pd=0u as=0p ps=0u
M1158 Vdd a_711_780# Q2 w_557_759# pfet w=10u l=0.2u
+  ad=0p pd=0u as=0p ps=0u
M1159 Q5 a_1361_780# Vdd w_1211_757# pfet w=10u l=0.2u
+  ad=0p pd=0u as=0p ps=0u
M1160 Vdd a_597_1343# a_657_1354# w_561_1337# pfet w=3.6u l=0.2u
+  ad=0p pd=0u as=0p ps=0u
M1161 Vdd a_711_1360# Q1 w_561_1337# pfet w=10u l=0.2u
+  ad=0p pd=0u as=0p ps=0u
M1162 Q2 a_711_780# gnd Vss nfet w=9u l=0.2u
+  ad=0p pd=0u as=0p ps=0u
M1163 a_1307_194# a_1247_183# Vdd w_1208_184# pfet w=3.6u l=0.2u
+  ad=0p pd=0u as=0p ps=0u
M1164 gnd a_711_200# Q3 Vss nfet w=9u l=0.2u
+  ad=0p pd=0u as=0p ps=0u
M1165 Q5 a_1361_780# gnd Vss nfet w=9u l=0.2u
+  ad=0p pd=0u as=0p ps=0u
M1166 Q6 a_1361_1360# Vdd w_1207_1342# pfet w=10u l=0.2u
+  ad=0p pd=0u as=0p ps=0u
M1167 Vdd a_711_200# Q3 w_558_177# pfet w=10u l=0.2u
+  ad=0p pd=0u as=0p ps=0u
M1168 Q4 a_1361_200# Vdd w_1208_184# pfet w=10u l=0.2u
+  ad=0p pd=0u as=0p ps=0u
M1169 Vdd a_1307_1354# a_1361_1360# w_1207_1342# pfet w=11.1u l=0.2u
+  ad=0p pd=0u as=0p ps=0u
M1170 Vdd a_711_780# Q2 w_557_759# pfet w=10u l=0.2u
+  ad=0p pd=0u as=0p ps=0u
M1171 Q3 a_711_200# gnd Vss nfet w=9u l=0.2u
+  ad=0p pd=0u as=0p ps=0u
M1172 Q5 a_1361_780# Vdd w_1211_757# pfet w=10u l=0.2u
+  ad=0p pd=0u as=0p ps=0u
M1173 Vdd a_711_1360# Q1 w_561_1337# pfet w=10u l=0.2u
+  ad=0p pd=0u as=0p ps=0u
M1174 gnd a_1307_1354# a_1361_1360# Vss nfet w=6.5u l=0.2u
+  ad=0p pd=0u as=0p ps=0u
M1175 Q6 a_1361_1360# Vdd w_1207_1342# pfet w=10u l=0.2u
+  ad=0p pd=0u as=0p ps=0u
M1176 Q2 a_711_780# gnd Vss nfet w=9u l=0.2u
+  ad=0p pd=0u as=0p ps=0u
M1177 gnd a_1361_200# Q4 Vss nfet w=9u l=0.2u
+  ad=0p pd=0u as=0p ps=0u
M1178 Q6 a_1361_1360# Vdd w_1207_1342# pfet w=10u l=0.2u
+  ad=0p pd=0u as=0p ps=0u
M1179 Q4 a_1361_200# Vdd w_1208_184# pfet w=10u l=0.2u
+  ad=0p pd=0u as=0p ps=0u
M1180 gnd a_597_183# a_657_194# Vss nfet w=3.2u l=0.2u
+  ad=0p pd=0u as=0p ps=0u
M1181 Vdd a_711_200# Q3 w_558_177# pfet w=10u l=0.2u
+  ad=0p pd=0u as=0p ps=0u
M1182 gnd a_1361_1360# Q6 Vss nfet w=9u l=0.2u
+  ad=0p pd=0u as=0p ps=0u
M1183 Q4 a_1361_200# Vdd w_1208_184# pfet w=10u l=0.2u
+  ad=0p pd=0u as=0p ps=0u
M1184 Vdd a_1217_763# a_1247_763# w_1211_757# pfet w=4u l=0.2u
+  ad=0p pd=0u as=2.8p ps=9.4u
M1185 Vdd a_1361_780# Q5 w_1211_757# pfet w=10u l=0.2u
+  ad=0p pd=0u as=0p ps=0u
M1186 a_1217_183# A4 gnd Vss nfet w=0.4u l=0.2u
+  ad=0.2p pd=1.8u as=0p ps=0u
M1187 Q2 a_711_780# Vdd w_557_759# pfet w=10u l=0.2u
+  ad=0p pd=0u as=0p ps=0u
M1188 Vdd a_1361_780# Q5 w_1211_757# pfet w=10u l=0.2u
+  ad=0p pd=0u as=0p ps=0u
M1189 a_1307_1354# a_1247_1343# Vdd w_1207_1342# pfet w=3.6u l=0.2u
+  ad=4.32p pd=16.8u as=0p ps=0u
M1190 Q1 a_711_1360# Vdd w_561_1337# pfet w=10u l=0.2u
+  ad=0p pd=0u as=0p ps=0u
M1191 Q6 a_1361_1360# Vdd w_1207_1342# pfet w=10u l=0.2u
+  ad=0p pd=0u as=0p ps=0u
M1192 Q3 a_711_200# gnd Vss nfet w=9u l=0.2u
+  ad=0p pd=0u as=0p ps=0u
M1193 gnd a_1361_780# Q5 Vss nfet w=9u l=0.2u
+  ad=0p pd=0u as=0p ps=0u
M1194 Vdd a_1361_1360# Q6 w_1207_1342# pfet w=10u l=0.2u
+  ad=0p pd=0u as=0p ps=0u
M1195 a_597_1343# a_567_1343# gnd Vss nfet w=1.6u l=0.2u
+  ad=0.8p pd=4.2u as=0p ps=0u
M1196 gnd a_711_1360# Q1 Vss nfet w=9u l=0.2u
+  ad=0p pd=0u as=0p ps=0u
M1197 Q4 a_1361_200# Vdd w_1208_184# pfet w=10u l=0.2u
+  ad=0p pd=0u as=0p ps=0u
M1198 gnd a_1361_1360# Q6 Vss nfet w=9u l=0.2u
+  ad=0p pd=0u as=0p ps=0u
M1199 Vdd a_711_200# Q3 w_558_177# pfet w=10u l=0.2u
+  ad=0p pd=0u as=0p ps=0u
M1200 Q2 a_711_780# Vdd w_557_759# pfet w=10u l=0.2u
+  ad=0p pd=0u as=0p ps=0u
M1201 Vdd a_657_774# a_711_780# w_557_759# pfet w=11.1u l=0.2u
+  ad=0p pd=0u as=0p ps=0u
M1202 Q5 a_1361_780# Vdd w_1211_757# pfet w=10u l=0.2u
+  ad=0p pd=0u as=0p ps=0u
M1203 Q1 a_711_1360# Vdd w_561_1337# pfet w=10u l=0.2u
+  ad=0p pd=0u as=0p ps=0u
M1204 gnd a_1361_200# Q4 Vss nfet w=9u l=0.2u
+  ad=0p pd=0u as=0p ps=0u
M1205 Vdd A4 a_1217_183# w_1208_184# pfet w=1u l=0.2u
+  ad=0p pd=0u as=0.6p ps=3.2u
M1206 Vdd a_711_1360# Q1 w_561_1337# pfet w=10u l=0.2u
+  ad=0p pd=0u as=0p ps=0u
M1207 Q4 a_1361_200# gnd Vss nfet w=9u l=0.2u
+  ad=0p pd=0u as=0p ps=0u
M1208 Q2 a_711_780# Vdd w_557_759# pfet w=10u l=0.2u
+  ad=0p pd=0u as=0p ps=0u
M1209 Q6 a_1361_1360# Vdd w_1207_1342# pfet w=10u l=0.2u
+  ad=0p pd=0u as=0p ps=0u
M1210 Vdd a_1361_780# Q5 w_1211_757# pfet w=10u l=0.2u
+  ad=0p pd=0u as=0p ps=0u
M1211 Vdd a_1307_774# a_1361_780# w_1211_757# pfet w=11.1u l=0.2u
+  ad=0p pd=0u as=0p ps=0u
M1212 gnd a_711_780# Q2 Vss nfet w=9u l=0.2u
+  ad=0p pd=0u as=0p ps=0u
M1213 Q3 a_711_200# Vdd w_558_177# pfet w=10u l=0.2u
+  ad=0p pd=0u as=0p ps=0u
M1214 Vdd a_1361_200# Q4 w_1208_184# pfet w=10u l=0.2u
+  ad=0p pd=0u as=0p ps=0u
M1215 a_1247_1343# a_1217_1343# gnd Vss nfet w=1.6u l=0.2u
+  ad=0.8p pd=4.2u as=0p ps=0u
M1216 a_657_194# a_597_183# Vdd w_558_177# pfet w=3.6u l=0.2u
+  ad=4.32p pd=16.8u as=0p ps=0u
M1217 Vdd a_711_200# Q3 w_558_177# pfet w=10u l=0.2u
+  ad=0p pd=0u as=0p ps=0u
M1218 Vdd a_597_1343# a_657_1354# w_561_1337# pfet w=3.6u l=0.2u
+  ad=0p pd=0u as=0p ps=0u
M1219 Q2 a_711_780# Vdd w_557_759# pfet w=10u l=0.2u
+  ad=0p pd=0u as=0p ps=0u
M1220 Vdd a_1361_780# Q5 w_1211_757# pfet w=10u l=0.2u
+  ad=0p pd=0u as=0p ps=0u
M1221 a_657_774# a_597_763# gnd Vss nfet w=3.2u l=0.2u
+  ad=1.92p pd=7.6u as=0p ps=0u
M1222 gnd a_711_200# Q3 Vss nfet w=9u l=0.2u
+  ad=0p pd=0u as=0p ps=0u
M1223 a_711_200# a_657_194# Vdd w_558_177# pfet w=11.1u l=0.2u
+  ad=0p pd=0u as=0p ps=0u
M1224 Q6 a_1361_1360# Vdd w_1207_1342# pfet w=10u l=0.2u
+  ad=0p pd=0u as=0p ps=0u
M1225 Vdd a_1361_200# Q4 w_1208_184# pfet w=10u l=0.2u
+  ad=0p pd=0u as=0p ps=0u
M1226 gnd a_711_780# Q2 Vss nfet w=9u l=0.2u
+  ad=0p pd=0u as=0p ps=0u
M1227 Q1 a_711_1360# gnd Vss nfet w=9u l=0.2u
+  ad=0p pd=0u as=0p ps=0u
M1228 Vdd a_711_200# Q3 w_558_177# pfet w=10u l=0.2u
+  ad=0p pd=0u as=0p ps=0u
M1229 Q4 a_1361_200# Vdd w_1208_184# pfet w=10u l=0.2u
+  ad=0p pd=0u as=0p ps=0u
M1230 Q6 a_1361_1360# gnd Vss nfet w=9u l=0.2u
+  ad=0p pd=0u as=0p ps=0u
M1231 a_567_1343# A1 gnd Vss nfet w=0.4u l=0.2u
+  ad=0.2p pd=1.8u as=0p ps=0u
M1232 gnd a_657_194# a_711_200# Vss nfet w=6.5u l=0.2u
+  ad=0p pd=0u as=0p ps=0u
M1233 a_1361_200# a_1307_194# Vdd w_1208_184# pfet w=11.1u l=0.2u
+  ad=0p pd=0u as=0p ps=0u
M1234 Vdd a_1361_780# Q5 w_1211_757# pfet w=10u l=0.2u
+  ad=0p pd=0u as=0p ps=0u
M1235 Q4 a_1361_200# gnd Vss nfet w=9u l=0.2u
+  ad=0p pd=0u as=0p ps=0u
M1236 Vdd a_1361_780# Q5 w_1211_757# pfet w=10u l=0.2u
+  ad=0p pd=0u as=0p ps=0u
M1237 gnd a_1307_194# a_1361_200# Vss nfet w=6.5u l=0.2u
+  ad=0p pd=0u as=0p ps=0u
M1238 Vdd a_1361_1360# Q6 w_1207_1342# pfet w=10u l=0.2u
+  ad=0p pd=0u as=0p ps=0u
M1239 Q6 a_1361_1360# Vdd w_1207_1342# pfet w=10u l=0.2u
+  ad=0p pd=0u as=0p ps=0u
M1240 Q1 a_711_1360# Vdd w_561_1337# pfet w=10u l=0.2u
+  ad=0p pd=0u as=0p ps=0u
M1241 Q5 a_1361_780# gnd Vss nfet w=9u l=0.2u
+  ad=0p pd=0u as=0p ps=0u
M1242 Q3 a_711_200# Vdd w_558_177# pfet w=10u l=0.2u
+  ad=0p pd=0u as=0p ps=0u
M1243 Vdd a_1247_183# a_1307_194# w_1208_184# pfet w=3.6u l=0.2u
+  ad=0p pd=0u as=0p ps=0u
M1244 Q4 a_1361_200# Vdd w_1208_184# pfet w=10u l=0.2u
+  ad=0p pd=0u as=0p ps=0u
M1245 gnd a_1247_763# a_1307_774# Vss nfet w=3.2u l=0.2u
+  ad=0p pd=0u as=0p ps=0u
M1246 Q2 a_711_780# Vdd w_557_759# pfet w=10u l=0.2u
+  ad=0p pd=0u as=0p ps=0u
M1247 Q5 a_1361_780# Vdd w_1211_757# pfet w=10u l=0.2u
+  ad=0p pd=0u as=0p ps=0u
M1248 a_1307_1354# a_1247_1343# Vdd w_1207_1342# pfet w=3.6u l=0.2u
+  ad=0p pd=0u as=0p ps=0u
M1249 Q1 a_711_1360# Vdd w_561_1337# pfet w=10u l=0.2u
+  ad=0p pd=0u as=0p ps=0u
M1250 Vdd a_1361_1360# Q6 w_1207_1342# pfet w=10u l=0.2u
+  ad=0p pd=0u as=0p ps=0u
M1251 Q2 a_711_780# gnd Vss nfet w=9u l=0.2u
+  ad=0p pd=0u as=0p ps=0u
M1252 Vdd A6 a_1217_1343# w_1207_1342# pfet w=1u l=0.2u
+  ad=0p pd=0u as=0.6p ps=3.2u
M1253 a_657_194# a_597_183# Vdd w_558_177# pfet w=3.6u l=0.2u
+  ad=0p pd=0u as=0p ps=0u
M1254 gnd a_711_1360# Q1 Vss nfet w=9u l=0.2u
+  ad=0p pd=0u as=0p ps=0u
M1255 Q1 a_711_1360# Vdd w_561_1337# pfet w=10u l=0.2u
+  ad=0p pd=0u as=0p ps=0u
M1256 Vdd a_657_194# a_711_200# w_558_177# pfet w=11.1u l=0.2u
+  ad=0p pd=0u as=0p ps=0u
M1257 Q5 a_1361_780# gnd Vss nfet w=9u l=0.2u
+  ad=0p pd=0u as=0p ps=0u
M1258 gnd a_1361_1360# Q6 Vss nfet w=9u l=0.2u
+  ad=0p pd=0u as=0p ps=0u
M1259 Q3 a_711_200# Vdd w_558_177# pfet w=10u l=0.2u
+  ad=0p pd=0u as=0p ps=0u
M1260 Vdd a_1361_200# Q4 w_1208_184# pfet w=10u l=0.2u
+  ad=0p pd=0u as=0p ps=0u
M1261 Vdd a_657_774# a_711_780# w_557_759# pfet w=11.1u l=0.2u
+  ad=0p pd=0u as=0p ps=0u
M1262 Vdd a_1307_194# a_1361_200# w_1208_184# pfet w=11.1u l=0.2u
+  ad=0p pd=0u as=0p ps=0u
M1263 a_597_763# a_567_763# gnd Vss nfet w=1.6u l=0.2u
+  ad=0.8p pd=4.2u as=0p ps=0u
M1264 a_1307_774# a_1247_763# Vdd w_1211_757# pfet w=3.6u l=0.2u
+  ad=0p pd=0u as=0p ps=0u
M1265 a_657_1354# a_597_1343# gnd Vss nfet w=3.2u l=0.2u
+  ad=1.92p pd=7.6u as=0p ps=0u
M1266 Q2 a_711_780# Vdd w_557_759# pfet w=10u l=0.2u
+  ad=0p pd=0u as=0p ps=0u
M1267 Vdd a_1361_780# Q5 w_1211_757# pfet w=10u l=0.2u
+  ad=0p pd=0u as=0p ps=0u
M1268 Q6 a_1361_1360# Vdd w_1207_1342# pfet w=10u l=0.2u
+  ad=0p pd=0u as=0p ps=0u
M1269 Q1 a_711_1360# Vdd w_561_1337# pfet w=10u l=0.2u
+  ad=0p pd=0u as=0p ps=0u
M1270 a_711_780# a_657_774# gnd Vss nfet w=6.5u l=0.2u
+  ad=0p pd=0u as=0p ps=0u
M1271 Vdd a_1307_774# a_1361_780# w_1211_757# pfet w=11.1u l=0.2u
+  ad=0p pd=0u as=0p ps=0u
M1272 gnd a_711_1360# Q1 Vss nfet w=9u l=0.2u
+  ad=0p pd=0u as=0p ps=0u
M1273 gnd a_1361_200# Q4 Vss nfet w=9u l=0.2u
+  ad=0p pd=0u as=0p ps=0u
M1274 a_1247_763# a_1217_763# gnd Vss nfet w=1.6u l=0.2u
+  ad=0.8p pd=4.2u as=0p ps=0u
M1275 Q3 a_711_200# Vdd w_558_177# pfet w=10u l=0.2u
+  ad=0p pd=0u as=0p ps=0u
M1276 Vdd a_1361_200# Q4 w_1208_184# pfet w=10u l=0.2u
+  ad=0p pd=0u as=0p ps=0u
M1277 a_711_1360# a_657_1354# Vdd w_561_1337# pfet w=11.1u l=0.2u
+  ad=0p pd=0u as=0p ps=0u
M1278 a_1361_780# a_1307_774# gnd Vss nfet w=6.5u l=0.2u
+  ad=0p pd=0u as=0p ps=0u
M1279 a_711_780# a_657_774# Vdd w_557_759# pfet w=11.1u l=0.2u
+  ad=0p pd=0u as=0p ps=0u
M1280 a_711_1360# a_657_1354# gnd Vss nfet w=6.5u l=0.2u
+  ad=0p pd=0u as=0p ps=0u
M1281 Vdd a_711_780# Q2 w_557_759# pfet w=10u l=0.2u
+  ad=0p pd=0u as=0p ps=0u
M1282 Q3 a_711_200# Vdd w_558_177# pfet w=10u l=0.2u
+  ad=0p pd=0u as=0p ps=0u
M1283 Vdd a_1361_200# Q4 w_1208_184# pfet w=10u l=0.2u
+  ad=0p pd=0u as=0p ps=0u
M1284 Q1 a_711_1360# Vdd w_561_1337# pfet w=10u l=0.2u
+  ad=0p pd=0u as=0p ps=0u
M1285 Vdd a_567_763# a_597_763# w_557_759# pfet w=4u l=0.2u
+  ad=0p pd=0u as=2.8p ps=9.4u
M1286 Q5 a_1361_780# Vdd w_1211_757# pfet w=10u l=0.2u
+  ad=0p pd=0u as=0p ps=0u
M1287 a_567_183# A3 gnd Vss nfet w=0.4u l=0.2u
+  ad=0.2p pd=1.8u as=0p ps=0u
M1288 a_1361_780# a_1307_774# Vdd w_1211_757# pfet w=11.1u l=0.2u
+  ad=0p pd=0u as=0p ps=0u
M1289 Vdd a_711_780# Q2 w_557_759# pfet w=10u l=0.2u
+  ad=0p pd=0u as=0p ps=0u
M1290 gnd a_711_780# Q2 Vss nfet w=9u l=0.2u
+  ad=0p pd=0u as=0p ps=0u
M1291 Vdd a_711_1360# Q1 w_561_1337# pfet w=10u l=0.2u
+  ad=0p pd=0u as=0p ps=0u
M1292 Vdd a_1361_1360# Q6 w_1207_1342# pfet w=10u l=0.2u
+  ad=0p pd=0u as=0p ps=0u
M1293 Q3 a_711_200# gnd Vss nfet w=9u l=0.2u
+  ad=0p pd=0u as=0p ps=0u
M1294 gnd a_1361_780# Q5 Vss nfet w=9u l=0.2u
+  ad=0p pd=0u as=0p ps=0u
M1295 Q6 a_1361_1360# gnd Vss nfet w=9u l=0.2u
+  ad=0p pd=0u as=0p ps=0u
M1296 Q3 a_711_200# Vdd w_558_177# pfet w=10u l=0.2u
+  ad=0p pd=0u as=0p ps=0u
M1297 Vdd a_1361_200# Q4 w_1208_184# pfet w=10u l=0.2u
+  ad=0p pd=0u as=0p ps=0u
M1298 gnd a_657_1354# a_711_1360# Vss nfet w=6.5u l=0.2u
+  ad=0p pd=0u as=0p ps=0u
M1299 a_1361_1360# a_1307_1354# Vdd w_1207_1342# pfet w=11.1u l=0.2u
+  ad=0p pd=0u as=0p ps=0u
M1300 Q2 a_711_780# Vdd w_557_759# pfet w=10u l=0.2u
+  ad=0p pd=0u as=0p ps=0u
M1301 Vdd a_1361_780# Q5 w_1211_757# pfet w=10u l=0.2u
+  ad=0p pd=0u as=0p ps=0u
M1302 a_1361_1360# a_1307_1354# gnd Vss nfet w=6.5u l=0.2u
+  ad=0p pd=0u as=0p ps=0u
M1303 Vdd a_1361_1360# Q6 w_1207_1342# pfet w=10u l=0.2u
+  ad=0p pd=0u as=0p ps=0u
M1304 Vdd A3 a_567_183# w_558_177# pfet w=1u l=0.2u
+  ad=0p pd=0u as=0.6p ps=3.2u
M1305 gnd a_711_200# Q3 Vss nfet w=9u l=0.2u
+  ad=0p pd=0u as=0p ps=0u
M1306 Vdd a_711_1360# Q1 w_561_1337# pfet w=10u l=0.2u
+  ad=0p pd=0u as=0p ps=0u
M1307 Q4 a_1361_200# gnd Vss nfet w=9u l=0.2u
+  ad=0p pd=0u as=0p ps=0u
M1308 Vdd a_711_780# Q2 w_557_759# pfet w=10u l=0.2u
+  ad=0p pd=0u as=0p ps=0u
M1309 Vdd a_1361_1360# Q6 w_1207_1342# pfet w=10u l=0.2u
+  ad=0p pd=0u as=0p ps=0u
M1310 Vdd a_1361_200# Q4 w_1208_184# pfet w=10u l=0.2u
+  ad=0p pd=0u as=0p ps=0u
M1311 Q6 a_1361_1360# gnd Vss nfet w=9u l=0.2u
+  ad=0p pd=0u as=0p ps=0u
M1312 Vdd a_1247_183# a_1307_194# w_1208_184# pfet w=3.6u l=0.2u
+  ad=0p pd=0u as=0p ps=0u
M1313 Q1 a_711_1360# gnd Vss nfet w=9u l=0.2u
+  ad=0p pd=0u as=0p ps=0u
M1314 Vdd a_711_200# Q3 w_558_177# pfet w=10u l=0.2u
+  ad=0p pd=0u as=0p ps=0u
M1315 Q4 a_1361_200# Vdd w_1208_184# pfet w=10u l=0.2u
+  ad=0p pd=0u as=0p ps=0u
M1316 gnd a_1307_1354# a_1361_1360# Vss nfet w=6.5u l=0.2u
+  ad=0p pd=0u as=0p ps=0u
M1317 Q2 a_711_780# Vdd w_557_759# pfet w=10u l=0.2u
+  ad=0p pd=0u as=0p ps=0u
M1318 Q5 a_1361_780# Vdd w_1211_757# pfet w=10u l=0.2u
+  ad=0p pd=0u as=0p ps=0u
M1319 Vdd a_711_780# Q2 w_557_759# pfet w=10u l=0.2u
+  ad=0p pd=0u as=0p ps=0u
M1320 Q5 a_1361_780# Vdd w_1211_757# pfet w=10u l=0.2u
+  ad=0p pd=0u as=0p ps=0u
M1321 Vdd a_1247_1343# a_1307_1354# w_1207_1342# pfet w=3.6u l=0.2u
+  ad=0p pd=0u as=0p ps=0u
M1322 Vdd a_711_1360# Q1 w_561_1337# pfet w=10u l=0.2u
+  ad=0p pd=0u as=0p ps=0u
M1323 Vdd a_1361_1360# Q6 w_1207_1342# pfet w=10u l=0.2u
+  ad=0p pd=0u as=0p ps=0u
M1324 gnd a_711_200# Q3 Vss nfet w=9u l=0.2u
+  ad=0p pd=0u as=0p ps=0u
M1325 Q5 a_1361_780# gnd Vss nfet w=9u l=0.2u
+  ad=0p pd=0u as=0p ps=0u
M1326 Q1 a_711_1360# Vdd w_561_1337# pfet w=10u l=0.2u
+  ad=0p pd=0u as=0p ps=0u
M1327 Vdd a_711_200# Q3 w_558_177# pfet w=10u l=0.2u
+  ad=0p pd=0u as=0p ps=0u
M1328 Q1 a_711_1360# gnd Vss nfet w=9u l=0.2u
+  ad=0p pd=0u as=0p ps=0u
M1329 Q3 a_711_200# Vdd w_558_177# pfet w=10u l=0.2u
+  ad=0p pd=0u as=0p ps=0u
M1330 Vdd a_711_780# Q2 w_557_759# pfet w=10u l=0.2u
+  ad=0p pd=0u as=0p ps=0u
M1331 a_1307_774# a_1247_763# Vdd w_1211_757# pfet w=3.6u l=0.2u
+  ad=0p pd=0u as=0p ps=0u
M1332 Q3 a_711_200# gnd Vss nfet w=9u l=0.2u
+  ad=0p pd=0u as=0p ps=0u
M1333 Q4 a_1361_200# gnd Vss nfet w=9u l=0.2u
+  ad=0p pd=0u as=0p ps=0u
M1334 Vdd a_711_780# Q2 w_557_759# pfet w=10u l=0.2u
+  ad=0p pd=0u as=0p ps=0u
M1335 gnd a_1361_200# Q4 Vss nfet w=9u l=0.2u
+  ad=0p pd=0u as=0p ps=0u
M1336 Q5 a_1361_780# Vdd w_1211_757# pfet w=10u l=0.2u
+  ad=0p pd=0u as=0p ps=0u
M1337 Vdd a_1361_1360# Q6 w_1207_1342# pfet w=10u l=0.2u
+  ad=0p pd=0u as=0p ps=0u
M1338 Vdd a_711_1360# Q1 w_561_1337# pfet w=10u l=0.2u
+  ad=0p pd=0u as=0p ps=0u
M1339 Q2 a_711_780# gnd Vss nfet w=9u l=0.2u
+  ad=0p pd=0u as=0p ps=0u
M1340 Vdd a_657_1354# a_711_1360# w_561_1337# pfet w=11.1u l=0.2u
+  ad=0p pd=0u as=0p ps=0u
M1341 Q4 a_1361_200# Vdd w_1208_184# pfet w=10u l=0.2u
+  ad=0p pd=0u as=0p ps=0u
M1342 Vdd a_597_183# a_657_194# w_558_177# pfet w=3.6u l=0.2u
+  ad=0p pd=0u as=0p ps=0u
M1343 Q3 a_711_200# Vdd w_558_177# pfet w=10u l=0.2u
+  ad=0p pd=0u as=0p ps=0u
M1344 Vdd a_1361_200# Q4 w_1208_184# pfet w=10u l=0.2u
+  ad=0p pd=0u as=0p ps=0u
M1345 Q5 a_1361_780# Vdd w_1211_757# pfet w=10u l=0.2u
+  ad=0p pd=0u as=0p ps=0u
M1346 gnd a_597_763# a_657_774# Vss nfet w=3.2u l=0.2u
+  ad=0p pd=0u as=0p ps=0u
M1347 Q3 a_711_200# gnd Vss nfet w=9u l=0.2u
+  ad=0p pd=0u as=0p ps=0u
M1348 Vdd a_711_1360# Q1 w_561_1337# pfet w=10u l=0.2u
+  ad=0p pd=0u as=0p ps=0u
M1349 Q6 a_1361_1360# Vdd w_1207_1342# pfet w=10u l=0.2u
+  ad=0p pd=0u as=0p ps=0u
M1350 Q2 a_711_780# gnd Vss nfet w=9u l=0.2u
+  ad=0p pd=0u as=0p ps=0u
M1351 gnd a_711_1360# Q1 Vss nfet w=9u l=0.2u
+  ad=0p pd=0u as=0p ps=0u
M1352 a_711_200# a_657_194# gnd Vss nfet w=6.5u l=0.2u
+  ad=0p pd=0u as=0p ps=0u
M1353 a_1217_763# A5 gnd Vss nfet w=0.4u l=0.2u
+  ad=0.2p pd=1.8u as=0p ps=0u
M1354 gnd a_1361_1360# Q6 Vss nfet w=9u l=0.2u
+  ad=0p pd=0u as=0p ps=0u
M1355 Q4 a_1361_200# Vdd w_1208_184# pfet w=10u l=0.2u
+  ad=0p pd=0u as=0p ps=0u
M1356 Vdd a_711_200# Q3 w_558_177# pfet w=10u l=0.2u
+  ad=0p pd=0u as=0p ps=0u
M1357 Vdd a_1307_1354# a_1361_1360# w_1207_1342# pfet w=11.1u l=0.2u
+  ad=0p pd=0u as=0p ps=0u
M1358 gnd a_1361_200# Q4 Vss nfet w=9u l=0.2u
+  ad=0p pd=0u as=0p ps=0u
M1359 a_657_774# a_597_763# Vdd w_557_759# pfet w=3.6u l=0.2u
+  ad=0p pd=0u as=0p ps=0u
M1360 Q5 a_1361_780# Vdd w_1211_757# pfet w=10u l=0.2u
+  ad=0p pd=0u as=0p ps=0u
M1361 a_1361_200# a_1307_194# gnd Vss nfet w=6.5u l=0.2u
+  ad=0p pd=0u as=0p ps=0u
M1362 Q1 a_711_1360# Vdd w_561_1337# pfet w=10u l=0.2u
+  ad=0p pd=0u as=0p ps=0u
M1363 Q6 a_1361_1360# Vdd w_1207_1342# pfet w=10u l=0.2u
+  ad=0p pd=0u as=0p ps=0u
M1364 Vdd a_711_780# Q2 w_557_759# pfet w=10u l=0.2u
+  ad=0p pd=0u as=0p ps=0u
M1365 Vdd a_1361_1360# Q6 w_1207_1342# pfet w=10u l=0.2u
+  ad=0p pd=0u as=0p ps=0u
M1366 Vdd a_711_1360# Q1 w_561_1337# pfet w=10u l=0.2u
+  ad=0p pd=0u as=0p ps=0u
M1367 gnd a_1361_780# Q5 Vss nfet w=9u l=0.2u
+  ad=0p pd=0u as=0p ps=0u
M1368 Vdd A5 a_1217_763# w_1211_757# pfet w=1u l=0.2u
+  ad=0p pd=0u as=0.6p ps=3.2u
M1369 Vdd a_711_200# Q3 w_558_177# pfet w=10u l=0.2u
+  ad=0p pd=0u as=0p ps=0u
M1370 a_1307_194# a_1247_183# gnd Vss nfet w=3.2u l=0.2u
+  ad=0p pd=0u as=0p ps=0u
M1371 Q4 a_1361_200# Vdd w_1208_184# pfet w=10u l=0.2u
+  ad=0p pd=0u as=0p ps=0u
M1372 Vdd a_1361_200# Q4 w_1208_184# pfet w=10u l=0.2u
+  ad=0p pd=0u as=0p ps=0u
M1373 Vdd a_711_200# Q3 w_558_177# pfet w=10u l=0.2u
+  ad=0p pd=0u as=0p ps=0u
M1374 Vdd a_1247_1343# a_1307_1354# w_1207_1342# pfet w=3.6u l=0.2u
+  ad=0p pd=0u as=0p ps=0u
M1375 Vdd a_711_1360# Q1 w_561_1337# pfet w=10u l=0.2u
+  ad=0p pd=0u as=0p ps=0u
M1376 Q2 a_711_780# Vdd w_557_759# pfet w=10u l=0.2u
+  ad=0p pd=0u as=0p ps=0u
M1377 Vdd a_1361_780# Q5 w_1211_757# pfet w=10u l=0.2u
+  ad=0p pd=0u as=0p ps=0u
M1378 gnd a_711_780# Q2 Vss nfet w=9u l=0.2u
+  ad=0p pd=0u as=0p ps=0u
M1379 a_711_200# a_657_194# Vdd w_558_177# pfet w=11.1u l=0.2u
+  ad=0p pd=0u as=0p ps=0u
M1380 Q1 a_711_1360# gnd Vss nfet w=9u l=0.2u
+  ad=0p pd=0u as=0p ps=0u
M1381 gnd a_1361_780# Q5 Vss nfet w=9u l=0.2u
+  ad=0p pd=0u as=0p ps=0u
M1382 Q6 a_1361_1360# gnd Vss nfet w=9u l=0.2u
+  ad=0p pd=0u as=0p ps=0u
M1383 Vdd a_711_200# Q3 w_558_177# pfet w=10u l=0.2u
+  ad=0p pd=0u as=0p ps=0u
M1384 Q4 a_1361_200# Vdd w_1208_184# pfet w=10u l=0.2u
+  ad=0p pd=0u as=0p ps=0u
M1385 a_1217_1343# A6 gnd Vss nfet w=0.4u l=0.2u
+  ad=0.2p pd=1.8u as=0p ps=0u
M1386 a_711_780# a_657_774# Vdd w_557_759# pfet w=11.1u l=0.2u
+  ad=0p pd=0u as=0p ps=0u
M1387 gnd a_657_194# a_711_200# Vss nfet w=6.5u l=0.2u
+  ad=0p pd=0u as=0p ps=0u
M1388 a_1361_200# a_1307_194# Vdd w_1208_184# pfet w=11.1u l=0.2u
+  ad=0p pd=0u as=0p ps=0u
M1389 Vdd a_1247_763# a_1307_774# w_1211_757# pfet w=3.6u l=0.2u
+  ad=0p pd=0u as=0p ps=0u
M1390 gnd a_597_1343# a_657_1354# Vss nfet w=3.2u l=0.2u
+  ad=0p pd=0u as=0p ps=0u
M1391 Vdd a_1361_780# Q5 w_1211_757# pfet w=10u l=0.2u
+  ad=0p pd=0u as=0p ps=0u
M1392 Vdd a_711_780# Q2 w_557_759# pfet w=10u l=0.2u
+  ad=0p pd=0u as=0p ps=0u
M1393 Vdd a_567_1343# a_597_1343# w_561_1337# pfet w=4u l=0.2u
+  ad=0p pd=0u as=2.8p ps=9.4u
M1394 Q5 a_1361_780# Vdd w_1211_757# pfet w=10u l=0.2u
+  ad=0p pd=0u as=0p ps=0u
M1395 Vdd a_711_1360# Q1 w_561_1337# pfet w=10u l=0.2u
+  ad=0p pd=0u as=0p ps=0u
M1396 gnd a_657_774# a_711_780# Vss nfet w=6.5u l=0.2u
+  ad=0p pd=0u as=0p ps=0u
M1397 a_1361_780# a_1307_774# Vdd w_1211_757# pfet w=11.1u l=0.2u
+  ad=0p pd=0u as=0p ps=0u
M1398 gnd a_1307_194# a_1361_200# Vss nfet w=6.5u l=0.2u
+  ad=0p pd=0u as=0p ps=0u
M1399 Q1 a_711_1360# gnd Vss nfet w=9u l=0.2u
+  ad=0p pd=0u as=0p ps=0u
M1400 Q4 a_1361_200# gnd Vss nfet w=9u l=0.2u
+  ad=0p pd=0u as=0p ps=0u
M1401 Vdd a_711_200# Q3 w_558_177# pfet w=10u l=0.2u
+  ad=0p pd=0u as=0p ps=0u
M1402 Q5 a_1361_780# gnd Vss nfet w=9u l=0.2u
+  ad=0p pd=0u as=0p ps=0u
M1403 Q6 a_1361_1360# Vdd w_1207_1342# pfet w=10u l=0.2u
+  ad=0p pd=0u as=0p ps=0u
M1404 Q4 a_1361_200# Vdd w_1208_184# pfet w=10u l=0.2u
+  ad=0p pd=0u as=0p ps=0u
M1405 Vdd a_657_1354# a_711_1360# w_561_1337# pfet w=11.1u l=0.2u
+  ad=0p pd=0u as=0p ps=0u
M1406 Vdd a_597_183# a_657_194# w_558_177# pfet w=3.6u l=0.2u
+  ad=0p pd=0u as=0p ps=0u
M1407 gnd a_1307_774# a_1361_780# Vss nfet w=6.5u l=0.2u
+  ad=0p pd=0u as=0p ps=0u
M1408 Vdd a_657_774# a_711_780# w_557_759# pfet w=11.1u l=0.2u
+  ad=0p pd=0u as=0p ps=0u
M1409 Q3 a_711_200# Vdd w_558_177# pfet w=10u l=0.2u
+  ad=0p pd=0u as=0p ps=0u
M1410 Q4 a_1361_200# Vdd w_1208_184# pfet w=10u l=0.2u
+  ad=0p pd=0u as=0p ps=0u
M1411 Vdd a_1361_780# Q5 w_1211_757# pfet w=10u l=0.2u
+  ad=0p pd=0u as=0p ps=0u
M1412 Vdd a_1307_774# a_1361_780# w_1211_757# pfet w=11.1u l=0.2u
+  ad=0p pd=0u as=0p ps=0u
M1413 Q2 a_711_780# Vdd w_557_759# pfet w=10u l=0.2u
+  ad=0p pd=0u as=0p ps=0u
.ends
